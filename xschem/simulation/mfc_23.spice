** sch_path: /home/ttuser/Mfcs/mfc_23/xschem/mfc_23.sch
.subckt mfc_23 gate sbd
*.PININFO gate:I sbd:O
XM2 sbd gate sbd sbd sky130_fd_pr__nfet_01v8 L=0.6 W=3.36 nf=1 m=1
.ends
.end
